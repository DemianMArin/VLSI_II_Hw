// Design: ece6443lib/inv_x1_tb
simulator lang=spectre
global 0
parameters vin=0 vdd=1 vss=0
include "/ALL_PDK/gpdk045_v_6_0/gpdk045/../models/spectre/gpdk045.scs" section=mc

// ece6443lib/inv_x1/schematic
subckt inv_x1 In Out Vdd Vss
    NM0 (Out In Vss Vss) g45n1svt w=(240n) l=45n nf=1 m=(1)
    PM0 (Out In Vdd Vdd) g45p1svt w=(480n) l=45n nf=1 m=(1)
ends inv_x1

// ece6443lib/inv_x1_tb/schematic
I0 (IN OUT Vdd Vss) inv_x1
V2 (Vss 0) vsource dc=vss type=dc
V1 (Vdd 0) vsource dc=vdd type=dc
V8 (IN 0) vsource dc=vdd type=pulse val0=1 val1=0 period=1u rise=5p fall=5p width=500n
C0 (OUT 0) capacitor c=2f
simulatorOptions options temp=27
tran tran stop=10u step=0.001u
dcOp dc
saveOptions options pwr=all currents=all
